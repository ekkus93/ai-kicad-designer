.title KiCad schematic
.include "GDZ16B.lib"
.include "LM3886.lib"
L1 Net-_L1-Pad1_ OUT 0.7u
R8 Net-_L1-Pad1_ OUT 10
D1 Net-_C5-Pad1_ Net-_D1-Pad1_ GDZ16B
XU1 Net-_C2-Pad1_ Net-_C4-Pad2_ V+ V- Net-_L1-Pad1_ Net-_D1-Pad1_ lm3886
C5 Net-_C5-Pad1_ GND 100u
R6 Net-_C5-Pad1_ V- 10k
R1 Net-_C1-Pad1_ GND 20k
C2 Net-_C2-Pad1_ GND 680p
R3 Net-_C4-Pad2_ Net-_C3-Pad1_ 1k
C3 Net-_C3-Pad1_ GND 470u
V1 IN GND dc 0 ac 1 sin(0 1 1k)
C1 Net-_C1-Pad1_ IN 4.7u
VN1 V- GND dc -30
VP1 V+ GND dc 30
R2 Net-_C2-Pad1_ Net-_C1-Pad1_ 1k
C4 Net-_C4-Pad1_ Net-_C4-Pad2_ 50p
R4 Net-_C4-Pad2_ Net-_L1-Pad1_ 20k
R5 Net-_C4-Pad1_ Net-_L1-Pad1_ 20k
RL1 OUT GND 6
C6 Net-_C6-Pad1_ GND 20n
R7 Net-_L1-Pad1_ Net-_C6-Pad1_ 4.7
.tran 10u 100m
.end
