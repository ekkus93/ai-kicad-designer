.title KiCad schematic
.include "1N4002G.spice.txt"
.include "BC546.lib"
.include "BC556.lib"
.include "VDMOS_models.lib"
R5 /out Net-_Q2-Pad2_ 47k
R12 Net-_Q4-Pad2_ Net-_Q1-Pad1_ 4.7k
C4 Net-_C4-Pad1_ 0 100u
R7 Net-_Q3-Pad2_ Net-_M6-Pad2_ 1k
R14 Net-_Q2-Pad2_ Net-_C4-Pad1_ 2.2k
Q2 VSS Net-_Q2-Pad2_ Net-_Q1-Pad3_ BC556B
C3 Net-_C3-Pad1_ /out 47u
R4 VCC Net-_C2-Pad1_ 1.2k
C2 Net-_C2-Pad1_ 0 47u
R3 Net-_C2-Pad1_ Net-_Q1-Pad3_ 15k
Rl1 Net-_L1-Pad1_ 0 8
L1 Net-_L1-Pad1_ /out 1u
C5 Net-_C5-Pad1_ 0 68n
R15 /out Net-_C5-Pad1_ 10
M6 VSS Net-_M6-Pad2_ /out /Tj6 /Tcase6 IRFP9240  thermal
Q4 Net-_M6-Pad2_ Net-_Q4-Pad2_ VSS BC546B
C7 0 VSS 100u
VN1 0 VSS dc 0 pulse ( 0 30 'ondelay' 1m 1m 'simtime')
Ch6 Net-_Ch6-Pad1_ 0 300m
Rh6 Net-_Ch6-Pad1_ Net-_Rh5-Pad2_ 1.5
Rch6 /Tcase6 Net-_Ch6-Pad1_ 0.5
Rj5 /Tj5 0 1G
Rj6 /Tj6 0 1G
Rh5 Net-_Ch5-Pad1_ Net-_Rh5-Pad2_ 1.5
Rch5 /Tcase5 Net-_Ch5-Pad1_ 0.5
Ch5 Net-_Ch5-Pad1_ 0 300m
VP1 VCC 0 dc 0 pulse ( 0 30 'ondelay' 1m 1m 'simtime')
Vamb1 Net-_Rh5-Pad2_ 0 'etemp'
C1 Net-_C1-Pad1_ 0 220p
Q1 Net-_Q1-Pad1_ Net-_C1-Pad1_ Net-_Q1-Pad3_ BC556B
R2 Net-_C1-Pad1_ 0 47k
R1 Net-_C1-Pad1_ /in 4.7k
Vin1 /in 0 dc 0 sin(0 1 100 'indelay')
R13 Net-_Q1-Pad1_ VSS 560
R11 VCC Net-_C3-Pad1_ 2.7k
R9 Net-_D1-Pad2_ Net-_Q3-Pad1_ 680
R10 Net-_C3-Pad1_ Net-_Q3-Pad1_ 2.7k
Q3 Net-_Q3-Pad1_ Net-_Q3-Pad2_ Net-_M6-Pad2_ BC546B
C6 VCC 0 100u
D1 Net-_D1-Pad2_ VCC DI_1N4002G
M5 VCC Net-_D1-Pad2_ /out /Tj5 /Tcase5 IRFP240  thermal
R8 Net-_Q3-Pad1_ Net-_R6-Pad1_ 12k
R6 Net-_R6-Pad1_ Net-_Q3-Pad2_ 200
.param etemp=42 ondelay=100m indelay=200m simtime=3
.temp 'etemp'
.tran 10u 'simtime'
.end
