.title KiCad schematic
.include "F5models.lib"
.include "script1.txt"
D3a1 +32 Net-_D3a1-Pad1_ DMOD
D3b1 +32 Net-_D3a1-Pad1_ DMOD
D4a1 +32 Net-_D4a1-Pad1_ DMOD
R20 +32 Net-_D4a1-Pad1_ 1
D4b1 +32 Net-_D4a1-Pad1_ DMOD
R19 +32 Net-_D4a1-Pad1_ 1
MQ4 out Net-_Q4-Pad2_ Net-_D4a1-Pad1_ Q4tj Q4tc IRFP9240 thermal
R14 Net-_Q4-Pad2_ Net-_P1-Pad1_ 47.5
D1a1 Net-_D1a1-Pad2_ -32 DMOD
D1b1 Net-_D1a1-Pad2_ -32 DMOD
R16 Net-_Q6-Pad2_ Net-_P2-Pad1_ 47.5
MQ6 out Net-_Q6-Pad2_ Net-_D2a1-Pad2_ Q6tj Q6tc IRFP240 thermal
D2a1 Net-_D2a1-Pad2_ -32 DMOD
D2b1 Net-_D2a1-Pad2_ -32 DMOD
Rc2 Q3hs Net-_Rc2-Pad2_ 2
Rc1 Q3tc Q3hs 0.15
Cc2 Q4hs 0 1
Cc1 Q3hs 0 1
R24 Net-_D2a1-Pad2_ -32 1
R23 Net-_D2a1-Pad2_ -32 1
Cc4 Q6hs 0 1
Rc8 Q6hs Net-_Rc2-Pad2_ 2
Rc3 Q4tc Q4hs 0.15
Rc5 Q5tc Q5hs 0.15
Rc7 Q6tc Q6hs 0.15
Rc4 Q4hs Net-_Rc2-Pad2_ 2
Cc3 Q5hs 0 1
Vt1 Net-_Rc2-Pad2_ 0 40
V1 +32 0 dc 0 pulse(0 32 0.4m 2m 2m 100 200)
V2 -32 0 dc 0 pulse(0 -32 0.4m 2m 2m 100 200)
Rc6 Q5hs Net-_Rc2-Pad2_ 2
Rj3 Q5tj 0 1G
Rj2 Q4tj 0 1G
Rj1 Q3tj 0 1G
Rj4 Q6tj 0 1G
XP3 Net-_P3-Pad1_ 0 Net-_P3-Pad1_ RPOT value=200 ratio=0.5
R3 Net-_P3-Pad1_ 0 10
R4 0 Net-_P3-Pad1_ 10
R9 out Net-_P3-Pad1_ 220
MQ3 out Net-_Q3-Pad2_ Net-_D3a1-Pad1_ Q3tj Q3tc IRFP9240 thermal
R18 +32 Net-_D3a1-Pad1_ 1
R17 +32 Net-_D3a1-Pad1_ 1
R11 Net-_R11-Pad1_ Net-_P1-Pad1_ 2.2k
XP1 Net-_P1-Pad1_ +32 +32 RPOT value=5k ratio=0.11
XTH1 Net-_D3a1-Pad1_ Q3hs Net-_R11-Pad1_ th R25=4.7k
R7 out Net-_P3-Pad1_ 220
R8 out Net-_P3-Pad1_ 220
R13 Net-_Q3-Pad2_ Net-_P1-Pad1_ 47.5
JQ2 Net-_P2-Pad1_ Net-_Q1-Pad2_ Net-_P3-Pad1_ 2SJ74
R6 Net-_P2-Pad1_ -32 1k
Ra2 out Net-_Ra1-Pad1_ 1m
Ra1 Net-_Ra1-Pad1_ 0 R = 'TIME < 4 ? 8 : 4'
V3 in 0 dc 0 sin(0 2 1k 5m)
R2 in 0 47.5k
R10 out Net-_P3-Pad1_ 220
R12 Net-_R12-Pad1_ Net-_P2-Pad1_ 2.2k
XP2 Net-_P2-Pad1_ -32 -32 RPOT value=5k ratio=0.1
XTH2 Net-_D1a1-Pad2_ Q5hs Net-_R12-Pad1_ th R25=4.7k
R15 Net-_Q5-Pad2_ Net-_P2-Pad1_ 47.5
MQ5 out Net-_Q5-Pad2_ Net-_D1a1-Pad2_ Q5tj Q5tc IRFP240 thermal
R21 Net-_D1a1-Pad2_ -32 1
R22 Net-_D1a1-Pad2_ -32 1
R5 +32 Net-_P1-Pad1_ 1k
JQ1 Net-_P1-Pad1_ Net-_Q1-Pad2_ Net-_P3-Pad1_ 2SK170
R1 Net-_Q1-Pad2_ in 1k
.tran 20u 6
.end
