RC timing charge
V1 vcc 0 5.0
R1 vcc timing 57000
C1 timing 0 1e-05 ic=0
.tran 0.0006 1.2 uic
.control
set filetype=ascii
run
wrdata /home/phil/work/ai-kicad-designer/fixtures/pivot/experiments/post_poc_engineering_2026-10-22_run1/spice/timing.dat time v(timing)
quit
.endc
.end
