AI-generated RC low-pass AC validation from Devstral v4 proposal
V1 vin 0 DC 0 AC 1
R1 vin vout 10k
C1 vout 0 15n
.control
set filetype=ascii
ac dec 100 1 100k
wrdata rc_lowpass_ac.tsv frequency vdb(vout)
quit
.endc
.end
