AI-generated RC low-pass AC validation
V1 vin 0 DC 0 AC 1
R1 vin vout 15k
C1 vout 0 100n
.control
set filetype=ascii
ac dec 100 1 100k
wrdata rc_lowpass_ac.dat frequency vdb(vout)
quit
.endc
.end
