.title KiCad schematic
C2 Net-_U1-CONT_ /REF 10n
C1 Net-_U1-THRES_ /REF 10u
R2 Net-_U1-DISCH_ Net-_U1-THRES_ 47k
R1 /VCC Net-_U1-DISCH_ 10k
U1 __U1
D1 __D1
R3 /VCC Net-_D1-A_ 1k
J3 __J3
J2 __J2
J1 __J1
.end
